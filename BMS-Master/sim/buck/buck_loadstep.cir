* Load step 0.1 A -> 1 A -> 0.1 A at 12 V (tests C_ff / loop response)
V1 vbat 0 PWL(0 0 1m 12)
Lh vbat N001 1u
Rh N001 vin 50m
Cb vin 0 100u Rser=0.3
Cin vin 0 12u Rser=3m
Cinx vin 0 100n
Rent vin en 511k
Renb en 0 86.6k
Css ss 0 33n
X1 bst en fb 0 NC_01 ss sw vin TPS62933F_TRANS
Cboot bst sw 100n
L1 sw vout 8.2u Rser=83m
Cout vout 0 26u Rser=3m
Rfbt vout fb 71.5k
Cff vout fb 6.8p
Rfbb fb 0 10k
Iload vout 0 PULSE(0.1 1 6m 1u 1u 1m 3m)
.include TPS62933F_LTspice.lib
.options reltol=0.005 trtol=7 method=gear
.save V(vout) V(vin) V(sw) V(ss) V(en) V(fb) I(L1) I(Rh)
.tran 0 8m 0 20n
.meas tran vout_pre AVG V(vout) FROM 5.5m TO 6m
.meas tran vout_dip MIN V(vout) FROM 6m TO 6.5m
.meas tran vout_1A AVG V(vout) FROM 6.5m TO 7m
.meas tran vout_over MAX V(vout) FROM 7m TO 7.5m
.meas tran vout_post AVG V(vout) FROM 7.5m TO 8m
.meas tran dip PARAM vout_pre-vout_dip
.meas tran over PARAM vout_over-vout_1A
.end
