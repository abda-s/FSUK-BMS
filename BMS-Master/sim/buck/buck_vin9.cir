* Steady state at 9 V input (low LV battery), 1 A load
V1 vbat 0 PWL(0 0 1m 9)
Lh vbat N001 1u
Rh N001 vin 50m
Cb vin 0 100u Rser=0.3
Cin vin 0 12u Rser=3m
Cinx vin 0 100n
Rent vin en 511k
Renb en 0 86.6k
Css ss 0 33n
X1 bst en fb 0 NC_01 ss sw vin TPS62933F_TRANS
Cboot bst sw 100n
L1 sw vout 8.2u Rser=83m
Cout vout 0 26u Rser=3m
Rfbt vout fb 71.5k
Cff vout fb 6.8p
Rfbb fb 0 10k
Rload vout 0 6.5
.include TPS62933F_LTspice.lib
.options reltol=0.005 trtol=7 method=gear
.save V(vout) V(vin) V(sw) V(ss) V(en) V(fb) I(L1) I(Rh)
.tran 0 9m 0 20n
.meas tran vout_avg AVG V(vout) FROM 8m TO 9m
.meas tran vout_pp PP V(vout) FROM 8.5m TO 9m
.meas tran il_pp PP I(L1) FROM 8.5m TO 9m
.meas tran il_max MAX I(L1)
.meas tran vout_max MAX V(vout)
.meas tran pin AVG V(vin)*I(Rh) FROM 8m TO 9m
.meas tran pout AVG V(vout)*V(vout)/6.5 FROM 8m TO 9m
.meas tran eff PARAM pout/pin
.end
